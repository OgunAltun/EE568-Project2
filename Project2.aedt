# Ansys Electronics Desktop project, version 2022.1
materials:
  steel_1008: permeability{HUnit=A_per_meter BUnit=tesla curve (0, 0) (159.2, 0.2402) (318.3, 0.8654) (477.5, 1.1106) (636.6, 1.2458) (795.8, 1.331) (1591.5, 1.5) (3183.1, 1.6) (4774.6, 1.683) (6366.2, 1.741) (7957.7, 1.78) (15915.5, 1.905) (31831, 2.025) (47746.5, 2.085) (63662, 2.13) (79577.5, 2.165) (159155, 2.28) (318310, 2.485) (397887, 2.5851)} conductivity=2000000 mass_density=7872
  copper: permeability=0.999991 conductivity=58000000 mass_density=8933
  vacuum: permittivity=1
  steel_1008_2DSF0.950: permeability{HUnit=A_per_meter BUnit=tesla curve (0, 0) (159.2, 0.2282) (318.3, 0.82215) (477.5, 1.0551) (636.6, 1.18355) (795.8, 1.2645) (1591.5, 1.4251) (3183.1, 1.5202) (4774.6, 1.59915) (6366.2, 1.65435) (7957.7, 1.6915) (15915.5, 1.81075) (31831, 1.92575) (47746.5, 1.98375) (63662, 2.0275) (79577.5, 2.06175) (159155, 2.176) (318310, 2.38075) (397887, 2.480845) (1193657, 3.4817947)} conductivity=2000000 mass_density=7478.4
  steel_1008_2DSF0.970: permeability{HUnit=A_per_meter BUnit=tesla curve (0, 0) (159.2, 0.233) (318.3, 0.83945) (477.5, 1.0773) (636.6, 1.20845) (795.8, 1.2911) (1591.5, 1.45506) (3183.1, 1.55212) (4774.6, 1.63269) (6366.2, 1.68901) (7957.7, 1.7269) (15915.5, 1.84845) (31831, 1.96545) (47746.5, 2.02425) (63662, 2.0685) (79577.5, 2.10305) (159155, 2.2176) (318310, 2.42245) (397887, 2.522547) (1193657, 3.5235168)} conductivity=2000000 mass_density=7635.84
  copper_75C: conductivity=58000000
  NdFe35: CoordinateSystemType=Cylindrical permittivity=1 permeability=1.05 conductivity=625000 magnetic_coercivity{Magnitude=-985244.89A_per_meter DirComp1=1 DirComp2=0 DirComp3=0} lande_g_factor=2 mass_density=7400
  NdFe36: CoordinateSystemType=Cylindrical permittivity=1 permeability=1.05 conductivity=625000 magnetic_coercivity{Magnitude=-985244.89A_per_meter DirComp1=-1 DirComp2=0 DirComp3=0} lande_g_factor=2 mass_density=7400

design RMxprtDesign1 (RMxprt, Generic Rotating Machines, model units mm)
machine:
  Machine: RotorType=4 StatorType=0 SourceType=0 Structure=0 ImportRotor=0 ImportStator=0 StatorCenter=0 RotorCenter=0 ImportType MasterSlaveOnXais Fraction=0 AirGapLength=0mm DoubleSided=0
  Stator: NumberOfPoles=20 NumberOfSlots=24 SlotType=6 CircuitType=0
  Rotor: NumberOfPoles=20
  Shaft: MagneticShaft FrictionLoss=0W WindLoss=0W ReferenceSpeed=0rpm
  Stator Core: OuterDiameter=100mm InnerDiameter=60mm Length=100mm SteelType=steel_1008 StackingFactor=0.95 LaminationSectors=0 PressBoardThickness=0mm SkewWidth=0deg
  Stator Winding: WindingType=Whole-Coiled WindingLayers=1 ParallelBranches=2 ConductorsPerSlot=50 CoilPitch=1 EndAdjustment=0mm BaseInnerRadius=0mm TipInnerDiameter=0mm EndClearance=0mm CoilWrap=0mm SlotLiner=0mm WedgeThickness=0mm LayerInsulation=0mm BottomInsulation=0mm LimitedFillFactor=0.75 WdgNumberofPriodicMultipler=1 NumberOfStrands=0 WireWrap=0mm InterturnInsulation=0mm WireDiameter=0mm WireWidth=2.59mm WireThickness=1.02mm Gauge=STANDARDRECT CorrectionFactor=1 TopSpareSpace=0 BottomSpareSpace=0 ConductorType=copper
  Rotor Core: OuterDiameter=59mm InnerDiameter=20mm Length=120mm SteelType=steel_1008 StackingFactor=0.95 PressBoardThickness=0mm SkewWidth=0deg PoleType=1
  Rotor Field: ShoeInsulation=0mm PoleInsulation=0mm WindingClearance=0mm ExciterEfficiency=0 ExcitingCurrent=50A
  Core Slot: Hs0=0.5mm Hs1=0.5mm Hs2=10mm Bs0=0mm Bs1=4.5mm Bs2=4mm Rs=0mm ToothWidth=0mm
  Core Pole: SecondAirGap=0mm PoleBodyHeight=3mm PoleShoeHeight=5mm Off2x=0mm Off2y=0mm PoleArcOffset=0mm PoleBodyWidth=3mm PoleShoeWidth=6mm PoleStackingFactor=0.97 PoleSteelType=steel_1008 Bp1/Rp1=0mm Bp2/Rp2=0mm Bp2/RP2=0mm
  Field Winding: WindingType=RoundWire AxiClearance=0mm ConductorsPerPole=10 InterturnInsulation=0mm LimitedCrossHeight=0mm LimitedCrossWidth=0mm NumOfStrands=0 ParallelBranches=1 WindingFillet=0mm WireSize=1.628mm WireWrap=0mm ConductorType=copper NumberOfStrands=0 WireDiameter=1.628mm WireWidth=0mm WireThickness=0mm Gauge=14
setups:
  Setup1: GRM Generator RatedOutputPower=100 RatedVoltage=380V RatedSpeed=360rpm OperatingTemperature=75cel LoadType=IndependentGenerator RatedPowerFactor=0.8 Frequency=50Hz

design Maxwell2DDesign1 (Maxwell 2D, Transient, XY geometry, model units mm)
options: ComputeTransientInductance ModelDepth=100mm
variables:
  fractions = 2
geometry:
  Shaft [steel_1008_2DSF0.950] = user_primitive(RMxprt/Band, DiaGap=59.5mm, DiaYoke=20mm, Length=0mm, SegAngle=0deg, Fractions=1, HalfAxial=0, InfoCore=100)
  OuterRegion [vacuum] = user_primitive(RMxprt/Band, DiaGap=59.5mm, DiaYoke=100mm, Length=0mm, SegAngle=0deg, Fractions=fractions, HalfAxial=0, InfoCore=100)
  Tool = user_primitive(RMxprt/Band, DiaGap=59.5mm, DiaYoke=100mm, Length=0mm, SegAngle=0deg, Fractions=fractions, HalfAxial=0, InfoCore=1)
  Stator [steel_1008_2DSF0.950] = user_primitive(RMxprt/SlotCore, DiaGap=60mm, DiaYoke=100mm, Length=0mm, Skew=0deg, Slots=24, SlotType=6, Hs0=0.5mm, Hs01=0mm, Hs1=0.5mm, Hs2=10mm, Bs0=4mm, Bs1=4.5mm, Bs2=4mm, Rs=0mm, FilletType=0, HalfSlot=0, SegAngle=15deg, LenRegion=0mm, InfoCore=0)
  Coil_0 [copper_75C] = user_primitive(RMxprt/LapCoil, DiaGap=60mm, DiaYoke=100mm, Length=0mm, Skew=0deg, Slots=24, SlotType=6, Hs0=0.5mm, Hs1=0.5mm, Hs2=10mm, Bs0=4mm, Bs1=4.5mm, Bs2=4mm, Rs=0mm, FilletType=0, Layers=1, CoilPitch=2, EndExt=0mm, SpanExt=0mm, BendAngle=0deg, SegAngle=10deg, LenRegion=0mm, InfoCoil=2)
  Coil_1..Coil_11 [copper_75C], Coil_12..Coil_23 = Coil_0.duplicate_around_axis(axis=Z, angle=15deg, total=24)
  Coil_0.unite(Coil_12)
  Coil_1.unite(Coil_13)
  Coil_2.unite(Coil_14)
  Coil_3.unite(Coil_15)
  Coil_4.unite(Coil_16)
  Coil_5.unite(Coil_17)
  Coil_6.unite(Coil_18)
  Coil_7.unite(Coil_19)
  Coil_8.unite(Coil_20)
  Coil_9.unite(Coil_21)
  Coil_10.unite(Coil_22)
  Coil_11.unite(Coil_23)
  Tool_3 = Tool.copy()
  Shaft.subtract(Tool_3)
  Tool_4 = Tool.copy()
  Stator.subtract(Tool_4)
  Tool_5 = Tool.copy()
  Coil_0.subtract(Tool_5)
  Tool_6 = Tool.copy()
  Coil_1.subtract(Tool_6)
  Tool_7 = Tool.copy()
  Coil_2.subtract(Tool_7)
  Tool_8 = Tool.copy()
  Coil_3.subtract(Tool_8)
  Tool_9 = Tool.copy()
  Coil_4.subtract(Tool_9)
  Tool_10 = Tool.copy()
  Coil_5.subtract(Tool_10)
  Tool_11 = Tool.copy()
  Coil_6.subtract(Tool_11)
  Tool_12 = Tool.copy()
  Coil_7.subtract(Tool_12)
  Tool_13 = Tool.copy()
  Coil_8.subtract(Tool_13)
  Tool_14 = Tool.copy()
  Coil_9.subtract(Tool_14)
  Tool_15 = Tool.copy()
  Coil_10.subtract(Tool_15)
  Tool_16 = Tool.copy()
  Coil_11.subtract(Tool_16)
  Tool.delete()
  Polyline1 [non-model] = polyline(z=0mm, xy in mm: (-29.75, 0) (1.8216621e-15, 29.75) (29.75, 0), AngularArc from point 0 over 3 centre=(0mm, 0mm, 0mm) angle=-180deg plane=XY)
  PMCore1 [steel_1008_2DSF0.970] = user_primitive(RMxprt/PMCore.dll, DiaGap=58mm, DiaYoke=20mm, Length=0mm, Poles=20, PoleType=1, Embrace=0.7, ThickMag=8mm, WidthMag=45mm, Offset=0mm, Bridge=2mm, Rib=3mm, LenRegion=200mm, InfoCore=0)
  PMCore2 = user_primitive(RMxprt/PMCore.dll, DiaGap=58mm, DiaYoke=20mm, Length=0mm, Poles=20, PoleType=1, Embrace=0.7, ThickMag=8mm, WidthMag=45mm, Offset=0mm, Bridge=2mm, Rib=3mm, LenRegion=200mm, InfoCore=1)
  PMCore2_Separate5..PMCore2_Separate9 [NdFe36], PMCore2_Separate10..PMCore2_Separate13, PMCore2_Separate19 [NdFe35] = PMCore2.separate_bodies()
  PMCore2.delete()
  PMCore1.split(plane=ZX, keep=PositiveOnly)
  Circle1 [vacuum] = circle(normal=Z, centre=(0mm, 0mm, 0mm), radius=29.5mm, segments=144)
  Circle1.split(plane=ZX, keep=PositiveOnly)
  Circle2 [vacuum] = circle(normal=Z, centre=(0mm, 0mm, 0mm), radius=29.75mm, segments=144)
  Circle2.split(plane=ZX, keep=PositiveOnly)
  Circle3 [vacuum] = circle(normal=Z, centre=(0mm, 0mm, 0mm), radius=29.25mm, segments=144)
  Circle3.split(plane=ZX, keep=PositiveOnly)
motion:
  MotionSetup1: Band Move_Type=Rotate Coordinate_System=Global Axis=Z Is_Positive=true InitPos=0deg Angular_Velocity=360rpm Objects=Circle1
  Moving1: Moving Objects=[Shaft, PMCore1, PMCore2_Separate5..PMCore2_Separate13, PMCore2_Separate19, Circle3]
boundaries and excitations:
  VectorPotential1: Vector Potential Edges=OuterRegion.edge(at (0, 50, 0)) Value=0
  Independent1: Independent Edges=OuterRegion.edge(at (25, 0, 0))
  Dependent1: Dependent Edges=OuterRegion.edge(at (-25, 0, 0)) ReverseU Independent=Independent1 SameAsMaster=true
  PhA_0: Coil Objects=Coil_0 Conductor_number=50 Winding=PhaseA PolarityType=Positive
  PhB_1: Coil Objects=Coil_1 Conductor_number=50 Winding=PhaseB PolarityType=Positive
  PhBRe_1: Coil Objects=Coil_2 Conductor_number=50 Winding=PhaseB PolarityType=Negative
  PhCRe_2: Coil Objects=Coil_3 Conductor_number=50 Winding=PhaseC PolarityType=Negative
  PhC_2: Coil Objects=Coil_4 Conductor_number=50 Winding=PhaseC PolarityType=Positive
  PhA_3: Coil Objects=Coil_5 Conductor_number=50 Winding=PhaseA PolarityType=Positive
  PhARe_3: Coil Objects=Coil_6 Conductor_number=50 Winding=PhaseA PolarityType=Negative
  PhBRe_4: Coil Objects=Coil_7 Conductor_number=50 Winding=PhaseB PolarityType=Negative
  PhB_4: Coil Objects=Coil_8 Conductor_number=50 Winding=PhaseB PolarityType=Positive
  PhC_5: Coil Objects=Coil_9 Conductor_number=50 Winding=PhaseC PolarityType=Positive
  PhCRe_5: Coil Objects=Coil_10 Conductor_number=50 Winding=PhaseC PolarityType=Negative
  PhARe_6: Coil Objects=Coil_11 Conductor_number=50 Winding=PhaseA PolarityType=Negative
  PhaseA: Winding Group Type=Current IsSolid=false Current=0A ParallelBranchesNum=2
  PhaseB: Winding Group Type=Current IsSolid=false Current=0A ParallelBranchesNum=2
  PhaseC: Winding Group Type=Current IsSolid=false Current=0A ParallelBranchesNum=2
parameters:
  Torque_stator: Torque Coordinate_System=Global Is_Positive=true Objects=Stator
mesh:
  CylindricalGap1: CylindricalGap Objects=Circle1
  initial mesh: MeshMethod=AnsoftTAU
setups:
  Setup1: Transient NonlinearSolverResidual=1e-06 StopTime=0.2s TimeStep="(0.2/144) s" SaveFieldsType="Every N Steps" N_Steps=200 Steps_From=0s Steps_To=0.2s NumberSolveSteps=1 RangeStart=0s RangeEnd=0.1s InitialTimeStep=0.002s MinTimeStep=0.001s MaxTimeStep=0.003s TimeStepErrTolerance=0.0001
output variables:
  pos = (Moving1.Position -9 * PI/180) * 10 + PI
  cos0 = cos(pos)
  cos1 = cos(pos-2*PI/3)
  cos2 = cos(pos-4*PI/3)
  sin0 = sin(pos)
  sin1 = sin(pos-2*PI/3)
  sin2 = sin(pos-4*PI/3)
  Lad = L(PhaseA,PhaseA)*cos0 + L(PhaseA,PhaseB)*cos1 + L(PhaseA,PhaseC)*cos2
  Laq = L(PhaseA,PhaseA)*sin0 + L(PhaseA,PhaseB)*sin1 + L(PhaseA,PhaseC)*sin2
  Lbd = L(PhaseB,PhaseA)*cos0 + L(PhaseB,PhaseB)*cos1 + L(PhaseB,PhaseC)*cos2
  Lbq = L(PhaseB,PhaseA)*sin0 + L(PhaseB,PhaseB)*sin1 + L(PhaseB,PhaseC)*sin2
  Lcd = L(PhaseC,PhaseA)*cos0 + L(PhaseC,PhaseB)*cos1 + L(PhaseC,PhaseC)*cos2
  Lcq = L(PhaseC,PhaseA)*sin0 + L(PhaseC,PhaseB)*sin1 + L(PhaseC,PhaseC)*sin2
  L_d = (Lad*cos0 + Lbd*cos1 + Lcd*cos2) * 2/3
  L_q = (Laq*sin0 + Lbq*sin1 + Lcq*sin2) * 2/3
  Flux_d = (FluxLinkage(PhaseA)*cos0+FluxLinkage(PhaseB)*cos1+FluxLinkage(PhaseC)*cos2)*2/3
  Flux_q = (FluxLinkage(PhaseA)*sin0+FluxLinkage(PhaseB)*sin1+FluxLinkage(PhaseC)*sin2)*2/3
  I_d = (Current(PhaseA)*cos0 + Current(PhaseB)*cos1 + Current(PhaseC)*cos2)*2/3
  I_q = (Current(PhaseA)*sin0 + Current(PhaseB)*sin1 + Current(PhaseC)*sin2)*2/3
  Irms = sqrt(I_d^2+I_q^2)/sqrt(2)
  Pcu = 3*Irms^2*0
field calculator expressions:
  B_r = B_Vector | 2D_Normal | Dot
field plots:
  Mesh1: MeshPlots over Shaft, OuterRegion, Stator, Coil_0..Coil_11 on Setup1 : Transient at Time=-1
  B_Vector1, Mag_B1: B over Shaft, OuterRegion, Stator, Coil_0..Coil_11 on Setup1 : Transient at Time=-1
reports:
  Stator Currents: Current(PhaseA), Current(PhaseB), Current(PhaseC) vs Time on Setup1 : Transient
  Torque: Moving1.Torque vs Time on Setup1 : Transient
  L_dq: L_d, L_q vs Time on Setup1 : Transient
  Flux_dq: Flux_d, Flux_q vs Time on Setup1 : Transient
  I_dq: I_d, I_q vs Time on Setup1 : Transient
  Winding Plot 1: InducedVoltage(PhaseC) vs Time on Setup1 : Transient
  Calculator Expressions Plot 1: B_r vs Distance on Setup1 : Transient [Time=0s]
